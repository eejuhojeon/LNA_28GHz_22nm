ADE simulation setup
Run mode: Single Run, Sweeps and Corners
Tests:
  5280myHW2:Q2a:1: 5280myHW2/Q2a/schematic, simulator spectre
Global variables:
  Vd = 500m
  Vg = 400m
